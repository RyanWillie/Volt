Independent linear AC rl reference
Vdrive input 0 DC 0 AC 1
Rseries input output 100
Lshunt output 0 100m
.control
set numdgt=17
set wr_vecnames
set wr_singlescale
ac lin 1 159.15494309189535 159.15494309189535
wrdata observations.txt v(input) v(output) i(Vdrive)
quit
.endc
.end

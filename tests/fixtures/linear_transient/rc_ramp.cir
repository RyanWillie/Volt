Volt independently authored transient oracle: rc_ramp
Vdrive in 0 PWL(0 0 1m 1 2m 1 2.5m 0)
R1 in out 1000
C1 out 0 1u IC=0
.options method=trap maxord=2 reltol=1e-10 abstol=1e-14 vntol=1e-12
.control
set noaskquit
set numdgt=17
set wr_singlescale
set wr_vecnames
tran 1e-6 3m 0 1e-7 uic
wrdata rc_ramp.tsv v(out) i(Vdrive)
quit
.endc
.end

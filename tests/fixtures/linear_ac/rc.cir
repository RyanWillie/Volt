Independent linear AC rc reference
Vdrive input 0 DC 0 AC 1
Rseries input output 1k
Cshunt output 0 1u
.control
set numdgt=17
set wr_vecnames
set wr_singlescale
ac lin 1 159.15494309189535 159.15494309189535
wrdata observations.txt v(input) v(output) i(Vdrive)
quit
.endc
.end

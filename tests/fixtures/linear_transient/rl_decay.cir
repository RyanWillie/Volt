Volt independently authored transient oracle: rl_decay
R1 out 0 100
L1 out 0 100m IC=0.01
.options method=trap maxord=2 reltol=1e-10 abstol=1e-14 vntol=1e-12
.control
set noaskquit
set numdgt=17
set wr_singlescale
set wr_vecnames
tran 1e-6 3m 0 1e-7 uic
wrdata rl_decay.tsv v(out) i(L1)
quit
.endc
.end

Volt independently authored transient oracle: rlc_free
C1 out 0 10u IC=1
R1 out mid 10
L1 mid 0 10m IC=0
.options method=trap maxord=2 reltol=1e-10 abstol=1e-14 vntol=1e-12
.control
set noaskquit
set numdgt=17
set wr_singlescale
set wr_vecnames
tran 1e-6 3m 0 1e-7 uic
wrdata rlc_free.tsv v(out) i(L1)
quit
.endc
.end

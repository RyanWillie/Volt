Volt independently authored transient oracle: rl_startup
Vdrive in 0 DC 1
R1 in out 100
L1 out 0 100m IC=0
.options method=trap maxord=2 reltol=1e-10 abstol=1e-14 vntol=1e-12
.control
set noaskquit
set numdgt=17
set wr_singlescale
set wr_vecnames
tran 1e-6 3m 0 1e-7 uic
wrdata rl_startup.tsv v(out) i(L1) i(Vdrive)
quit
.endc
.end
